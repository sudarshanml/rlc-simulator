R1 in n1 10
C1 n1 0 1e-12
R2 n1 n2 10
C2 n2 0 1e-12
V1 in 0 PWL 0 0 25e-12 1.0 50e-12 0
.probe n1
.probe n2
